* OS0084 chip netlist generated by flow/assemble_chip.py
.include ../layout/frame/frame3mmx3mm_opad.cdl
.include core_cells.cdl
.include acc4_core.cir
.SUBCKT OS0084 PAD1 PAD2 PAD3 PAD4 PAD5 PAD6 PAD7 PAD8 PAD9 PAD10 PAD11 PAD12 PAD13 PAD14 PAD15 PAD16 PAD17 PAD18 PAD19 PAD20 PAD21 PAD22 PAD23 PAD24 VDD VSS
Xframe PAD1 PAD2 PAD3 PAD4 PAD5 PAD6 PAD7 PAD8 PAD9 PAD10 PAD11 PAD12 PAD13 PAD14 PAD15 PAD16 PAD17 PAD18 PAD19 PAD20 PAD21 PAD22 PAD23 PAD24 PAD2_OUT PAD4_OUT PAD6_OUT PAD8_OUT PAD10_OUT PAD12_OUT PAD14_OUT PAD16_OUT PAD18_OUT PAD20_OUT PAD22_OUT PAD24_OUT PAD1_IN PAD3_IN PAD5_IN PAD7_IN PAD9_IN PAD11_IN PAD13_IN PAD15_IN PAD17_IN PAD19_IN PAD21_IN PAD23_IN VDD VSS frame3mmx3mm_opad
Xcore PAD2_OUT PAD23_IN PAD19_IN PAD4_OUT PAD6_OUT PAD21_IN PAD9_IN PAD7_IN PAD5_IN PAD3_IN PAD1_IN PAD22_OUT PAD20_OUT PAD18_OUT PAD16_OUT PAD14_OUT PAD12_OUT PAD10_OUT PAD8_OUT PAD17_IN PAD15_IN PAD13_IN PAD11_IN VDD VSS acc4_core
.ENDS OS0084
