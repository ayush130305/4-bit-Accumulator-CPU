.include core_cells.cdl
.include acc4_core.cir
